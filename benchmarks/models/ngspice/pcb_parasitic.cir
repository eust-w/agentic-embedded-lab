AEL PCB rail parasitic transient model
.param trace_inductance='AEL_trace_inductance_nH*1n'
.param trace_resistance='AEL_trace_resistance_ohm'
.param decoupling='AEL_decoupling_uF*1u'
.param capacitor_esr='AEL_capacitor_esr_ohm'
.param load='AEL_load_mA*1m'
Vsource source 0 3.3
Ltrace source trace {trace_inductance}
Rtrace trace rail {trace_resistance}
Resr rail cap {capacitor_esr}
Cdec cap 0 {decoupling} ic=3.3
Iload rail 0 PWL(0 0 10u 0 11u {load} 200u {load})
.tran 0.1u 200u uic
.measure tran ael_supply_voltage MIN v(rail) FROM=10u TO=200u
.measure tran ael_ringing_peak MAX v(rail) FROM=10u TO=200u
.measure tran ael_final_voltage FIND v(rail) AT=199u
.measure tran ael_droop PARAM='3.3-ael_supply_voltage'
.measure tran ael_ripple PARAM='ael_ringing_peak-ael_supply_voltage'
.measure tran ael_failure PARAM='ael_supply_voltage < 2.7'
.end
